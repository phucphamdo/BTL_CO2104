* Lab 4 - Ex01: non-inverting amplifier
V1 in 0 2
X1 in fb out vcc vee OPAMP
R1 fb 0 1k
Rf out fb 1k
.op
* behavioural op-amp (rails = supply -/+ 1.5 V)
.subckt OPAMP inp inn out vcc vee
Rin inp inn 10Meg
B1 out 0 V=limit(1e6*(V(inp)-V(inn)),V(vee)+1.5,V(vcc)-1.5)
.ends
.model QN NPN(Is=1e-14 Bf=100 Br=1)
V+ vcc 0 15
V- vee 0 -15
