* Lab 6 - Ex05: diode circuit with a 30 V battery
V1 s 0 30
R1 s n1 1k
R2 n1 m 1.5k
R3 m 0 4.7k
R4 m a 4.7k
D1 a 0 D1N4148
.op
* models
.model D1N4148 D(Is=2.52n Rs=0.568 N=1.752 Cjo=4p M=0.4 Tt=20n)
.model DZ12 D(Is=1e-14 Bv=12 Ibv=10m Rs=2)
.model DZ51 D(Is=1e-14 Bv=5.1 Ibv=10m Rs=2)
.model DZ17 D(Is=1e-14 Bv=1.7 Ibv=1m Rs=2)
.model QN NPN(Is=1e-14 Bf=100 Br=1)
