* Lab 5 - Ex04: JFET self-bias
V1 vdd 0 15
RD vdd d 1.2k
RG g 0 1Meg
RS s 0 470
J1 d g s JN
.op
* models
.model JN NJF(Beta=2.5m Vto=-2 Lambda=0.01)
.model DMOS NMOS(Kp=1.78m Vto=-3 Lambda=0.01)
.model NM NMOS(Kp=2m Vto=2 Lambda=0.01)
.model NMSW NMOS(Kp=0.5 Vto=2)
.model PM PMOS(Kp=1m Vto=-2 Lambda=0.01)
.model D1N4148 D(Is=2.52n Rs=0.568 N=1.752 Cjo=4p M=0.4 Tt=20n)
