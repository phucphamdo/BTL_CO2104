* Lab 5 - Adv02: CMOS inverter transfer characteristic and switching
V1 vdd 0 5
Vin in 0 0
M1 out in 0 0 NM
M2 out in vdd vdd PM
.dc Vin 0 5 0.01
* models
.model JN NJF(Beta=2.5m Vto=-2 Lambda=0.01)
.model DMOS NMOS(Kp=1.78m Vto=-3 Lambda=0.01)
.model NM NMOS(Kp=2m Vto=2 Lambda=0.01)
.model NMSW NMOS(Kp=0.5 Vto=2)
.model PM PMOS(Kp=1m Vto=-2 Lambda=0.01)
.model D1N4148 D(Is=2.52n Rs=0.568 N=1.752 Cjo=4p M=0.4 Tt=20n)
