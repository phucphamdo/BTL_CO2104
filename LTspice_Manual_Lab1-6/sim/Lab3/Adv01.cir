* Lab 3 - Adv01: Q-point versus beta for the voltage-divider bias circuit
.param BF=100
.model QV NPN(Is=1e-14 Bf={BF} Br=1)
V1 vcc 0 12
R1 vcc b 47k
R2 b 0 10k
RC vcc c 2.2k
RE e 0 1k
Q1 c b e QV
.step param BF list 50 100 200
.dc V1 12 12 1
.meas DC Ic FIND I(RC) AT=12
.meas DC Vce FIND V(c,e) AT=12
