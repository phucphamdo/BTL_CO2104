* Lab 3 - Adv02: common-emitter amplifier, AC analysis
.model QA NPN(Is=1e-14 Bf=100 Br=1 Vaf=100 Cje=10p Cjc=4p Tf=0.4n)
V1 vcc 0 12
Vin in 0 AC 1
Cin in b 10u
R1 vcc b 47k
R2 b 0 10k
RC vcc c 2.2k
RE e 0 1k
CE e 0 100u
Q1 c b e QA
Cout c out 10u
RL out 0 10k
.ac dec 20 10 100Meg
