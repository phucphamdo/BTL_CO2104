* Lab 1 - Ex02: equivalent resistance between A and F
V1 A 0 12
R1 A B 2
R2 B C 3
R3 C X 4
R4 X Y 5
R5 Y E 3
R6 C E 4
R7 B E 6
R8 E 0 1
.op
.end
