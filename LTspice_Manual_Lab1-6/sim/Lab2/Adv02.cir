* Lab 2 - Adv02: ripple of a bridge rectifier versus the filter capacitor
.param C=470u
V1 p 0 SINE(0 22 50)
D1 p c D1N4148
D2 0 c D1N4148
D3 d p D1N4148
D4 d 0 D1N4148
Rg d 0 1
R1 c d 1k
C1 c d {C}
.step param C list 100u 470u 1000u 2200u
.tran 0 200m 0 0.1m
.meas TRAN Vpp PP V(c,d) FROM=100m TO=200m
* models
.model D1N4148 D(Is=2.52n Rs=0.568 N=1.752 Cjo=4p M=0.4 Tt=20n)
.model DSCH D(Is=1u N=1.05 Rs=0.05 Cjo=100p)
.model DZ5V D(Is=1e-14 Bv=5.0 Ibv=10m Rs=2)
.model DZ22 D(Is=1e-14 Bv=22 Ibv=10m Rs=2)
.model DZ20 D(Is=1e-14 Bv=20 Ibv=10m Rs=2)
.model LEDRED D(Is=1e-18 N=1.9 Rs=5 Cjo=30p)
.model QN NPN(Is=1e-14 Bf=100 Br=1)
.model QP PNP(Is=1e-14 Bf=100 Br=1)
