* Lab 4 - Ex02: inverting amplifier
V1 in 0 2
R1 in inn 1k
Rf out inn 2k
X1 0 inn out vcc vee OPAMP
.op
* behavioural op-amp (rails = supply -/+ 1.5 V)
.subckt OPAMP inp inn out vcc vee
Rin inp inn 10Meg
B1 out 0 V=limit(1e6*(V(inp)-V(inn)),V(vee)+1.5,V(vcc)-1.5)
.ends
.model QN NPN(Is=1e-14 Bf=100 Br=1)
V+ vcc 0 15
V- vee 0 -15
