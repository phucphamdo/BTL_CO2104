* Lab 4 - Ex09: inverting Schmitt trigger
V1 in 0 SINE(0 10 100)
X1 p in out vcc vee OPAMP
R1 out p 10k
R2 p 0 10k
.tran 0 40m 0 10u
* behavioural op-amp (rails = supply -/+ 1.5 V)
.subckt OPAMP inp inn out vcc vee
Rin inp inn 10Meg
B1 out 0 V=limit(1e6*(V(inp)-V(inn)),V(vee)+1.5,V(vcc)-1.5)
.ends
.model QN NPN(Is=1e-14 Bf=100 Br=1)
V+ vcc 0 15
V- vee 0 -15
