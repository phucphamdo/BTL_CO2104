* Lab 2 - Ex07: full-wave bridge rectifier with a 10:1 transformer
V1 p 0 SINE(0 220 50)
L1 p 0 10
L2 a b 0.1
K1 L1 L2 1
Rg b 0 100Meg
D1 a c D1N4148
D2 b c D1N4148
D3 d a D1N4148
D4 d b D1N4148
R1 c d 1k
.tran 0 100m 0 0.1m
* models
.model D1N4148 D(Is=2.52n Rs=0.568 N=1.752 Cjo=4p M=0.4 Tt=20n)
.model DSCH D(Is=1u N=1.05 Rs=0.05 Cjo=100p)
.model DZ5V D(Is=1e-14 Bv=5.0 Ibv=10m Rs=2)
.model DZ22 D(Is=1e-14 Bv=22 Ibv=10m Rs=2)
.model DZ20 D(Is=1e-14 Bv=20 Ibv=10m Rs=2)
.model LEDRED D(Is=1e-18 N=1.9 Rs=5 Cjo=30p)
.model QN NPN(Is=1e-14 Bf=100 Br=1)
.model QP PNP(Is=1e-14 Bf=100 Br=1)
