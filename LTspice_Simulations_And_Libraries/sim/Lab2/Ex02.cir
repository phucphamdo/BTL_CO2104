* Lab 2 - Ex02: three diodes in series
V1 in 0 10
D1 in a D1N4148
D2 a b D1N4148
D3 b c D1N4148
R1 c 0 1k
.op
* models
.model D1N4148 D(Is=2.52n Rs=0.568 N=1.752 Cjo=4p M=0.4 Tt=20n)
.model DSCH D(Is=1u N=1.05 Rs=0.05 Cjo=100p)
.model DZ5V D(Is=1e-14 Bv=5.0 Ibv=10m Rs=2)
.model DZ22 D(Is=1e-14 Bv=22 Ibv=10m Rs=2)
.model DZ20 D(Is=1e-14 Bv=20 Ibv=10m Rs=2)
.model LEDRED D(Is=1e-18 N=1.9 Rs=5 Cjo=30p)
.model QN NPN(Is=1e-14 Bf=100 Br=1)
.model QP PNP(Is=1e-14 Bf=100 Br=1)
