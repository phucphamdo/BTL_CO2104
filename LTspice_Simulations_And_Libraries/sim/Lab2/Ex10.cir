* Lab 2 - Ex10: buck converter built from discrete parts (replaces the LM2596 exercise)
V1 in 0 12
V2 ctl 0 PULSE(0 5 0 10n 10n 5u 10u)
S1 in sw ctl 0 SW
D1 0 sw DSCH
L1 sw out 33u
C1 out 0 220u
RL out 0 10
.model SW SW(Ron=0.05 Roff=1Meg Vt=2.5 Vh=0.1)
.tran 0 3m 0 0.2u
* models
.model D1N4148 D(Is=2.52n Rs=0.568 N=1.752 Cjo=4p M=0.4 Tt=20n)
.model DSCH D(Is=1u N=1.05 Rs=0.05 Cjo=100p)
.model DZ5V D(Is=1e-14 Bv=5.0 Ibv=10m Rs=2)
.model DZ22 D(Is=1e-14 Bv=22 Ibv=10m Rs=2)
.model DZ20 D(Is=1e-14 Bv=20 Ibv=10m Rs=2)
.model LEDRED D(Is=1e-18 N=1.9 Rs=5 Cjo=30p)
.model QN NPN(Is=1e-14 Bf=100 Br=1)
.model QP PNP(Is=1e-14 Bf=100 Br=1)
