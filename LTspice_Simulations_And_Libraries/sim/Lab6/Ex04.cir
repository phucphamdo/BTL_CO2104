* Lab 6 - Ex04: diode in a resistor bridge (10 V)
V1 s 0 10
R1 s t 2k
R2 s u 4k
D1 t u D1N4148
R3 t 0 8k
R4 u 0 6k
.op
* models
.model D1N4148 D(Is=2.52n Rs=0.568 N=1.752 Cjo=4p M=0.4 Tt=20n)
.model DZ12 D(Is=1e-14 Bv=12 Ibv=10m Rs=2)
.model DZ51 D(Is=1e-14 Bv=5.1 Ibv=10m Rs=2)
.model DZ17 D(Is=1e-14 Bv=1.7 Ibv=1m Rs=2)
.model QN NPN(Is=1e-14 Bf=100 Br=1)
