* Lab 6 - Ex08: BJT with a Zener reference at the base
V1 vcc 0 6
RB vcc b 8.6k
DZ 0 b DZ17
RL vcc c 400
Q1 c b e QN
RE e 0 100
.op
* models
.model D1N4148 D(Is=2.52n Rs=0.568 N=1.752 Cjo=4p M=0.4 Tt=20n)
.model DZ12 D(Is=1e-14 Bv=12 Ibv=10m Rs=2)
.model DZ51 D(Is=1e-14 Bv=5.1 Ibv=10m Rs=2)
.model DZ17 D(Is=1e-14 Bv=1.7 Ibv=1m Rs=2)
.model QN NPN(Is=1e-14 Bf=100 Br=1)
