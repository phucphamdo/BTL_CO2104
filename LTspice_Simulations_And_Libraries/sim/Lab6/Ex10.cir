* Lab 6 - Ex10: series regulator (Zener reference + BJT pass transistor)
.param RL=100
V1 in 0 12
R1 in b 1k
DZ 0 b DZ51
Q1 in b out QN
RL out 0 {RL}
.step param RL list 50 100 1k
.op
* models
.model D1N4148 D(Is=2.52n Rs=0.568 N=1.752 Cjo=4p M=0.4 Tt=20n)
.model DZ12 D(Is=1e-14 Bv=12 Ibv=10m Rs=2)
.model DZ51 D(Is=1e-14 Bv=5.1 Ibv=10m Rs=2)
.model DZ17 D(Is=1e-14 Bv=1.7 Ibv=1m Rs=2)
.model QN NPN(Is=1e-14 Bf=100 Br=1)
